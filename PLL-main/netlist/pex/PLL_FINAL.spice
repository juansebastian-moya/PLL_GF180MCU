* NGSPICE file created from PLL_FINAL.ext - technology: gf180mcuD

.subckt PLL_FINAL VDD_TEST D12 D0 UP_INPUT D13 D1 DN_INPUT VSS D14 D2 PRE_SCALAR UP_OUT D15 D3 F_IN DN_OUT D4 ITAIL DIV_OUT D5
+ S1 S6 D6 VCTRL_IN D7 S2 D8 S3 OUT D9 OUTB S4 LF_OFFCHIP D10 S5 S7 OUT1 VDD
R0 D3.n10 D3.n1 4.50234
R1 D3.n9 D3.n8 4.50161
R2 D3.n5 D3.n1 4.50124
R3 D3.n8 D3.n7 4.5005
R4 D3.n2 D3.n1 4.5005
R5 D3.n4 D3.n3 4.5005
R6 D3.n7 D3.n6 4.5005
R7 D3.n2 D3.n0 4.5005
R8 D3.n11 D3.n10 2.27897
R9 D3.n6 D3.n5 2.27824
R10 D3 D3.n11 0.109045
R11 D3.n3 D3.n1 0.0368547
R12 D3.n9 D3.n2 0.0313919
R13 D3.n7 D3.n4 0.0277432
R14 D3.n7 D3.n2 0.00366216
R15 D3.n6 D3.n0 0.00366216
R16 D3.n11 D3.n0 0.00341892
R17 D3.n10 D3.n9 0.00233704
R18 D3.n5 D3.n4 0.00124322
R19 D3.n8 D3.n3 0.00094335
R20 S3.n14 S3.n13 7.75651
R21 S3.n19 S3.n18 4.55881
R22 S3.n15 S3.n14 4.54383
R23 S3.n11 S3.n4 4.50156
R24 S3.n5 S3.n4 4.5011
R25 S3.n9 S3.n8 4.5005
R26 S3.n10 S3.n3 4.5005
R27 S3.n4 S3.n3 4.5005
R28 S3.n7 S3.n6 4.5005
R29 S3.n8 S3.n2 4.5005
R30 S3.n13 S3.n12 4.5005
R31 S3.n17 S3.n16 4.5005
R32 S3.n1 S3.n0 4.5005
R33 S3.n15 S3.n0 2.36699
R34 S3.n18 S3.n17 2.33105
R35 S3.n9 S3.n5 2.25179
R36 S3.n11 S3.n10 2.25168
R37 S3 S3.n19 1.99512
R38 S3.n16 S3.n1 0.116489
R39 S3.n19 S3.n0 0.116489
R40 S3.n17 S3.n14 0.0648374
R41 S3.n18 S3.n1 0.0577148
R42 S3.n16 S3.n15 0.043034
R43 S3.n6 S3.n4 0.0335942
R44 S3.n12 S3.n3 0.0135182
R45 S3.n8 S3.n7 0.0119806
R46 S3.n8 S3.n3 0.00183257
R47 S3.n12 S3.n11 0.00156371
R48 S3.n13 S3.n2 0.00150897
R49 S3.n7 S3.n5 0.0011025
R50 S3.n6 S3.n2 0.000903587
R51 S3.n10 S3.n9 0.000596894
R52 VDD_TEST.n68 VDD_TEST.n46 13.4172
R53 VDD_TEST.n41 VDD_TEST.n33 4.52496
R54 VDD_TEST.n46 VDD_TEST.n45 4.50418
R55 VDD_TEST.n8 VDD_TEST.n7 4.50328
R56 VDD_TEST.n37 VDD_TEST.n35 4.50272
R57 VDD_TEST.n11 VDD_TEST.n0 4.50223
R58 VDD_TEST.n25 VDD_TEST.n21 4.50153
R59 VDD_TEST.n21 VDD_TEST.n20 4.50134
R60 VDD_TEST.n55 VDD_TEST.n51 4.50129
R61 VDD_TEST.n12 VDD_TEST.n11 4.50108
R62 VDD_TEST.n38 VDD_TEST.n37 4.50072
R63 VDD_TEST.n62 VDD_TEST.n52 4.5005
R64 VDD_TEST.n64 VDD_TEST.n63 4.5005
R65 VDD_TEST.n36 VDD_TEST.n34 4.5005
R66 VDD_TEST.n23 VDD_TEST.n17 4.5005
R67 VDD_TEST.n26 VDD_TEST.n18 4.5005
R68 VDD_TEST.n26 VDD_TEST.n25 4.5005
R69 VDD_TEST.n17 VDD_TEST.n16 4.5005
R70 VDD_TEST.n29 VDD_TEST.n28 4.5005
R71 VDD_TEST.n22 VDD_TEST.n21 4.5005
R72 VDD_TEST.n28 VDD_TEST.n27 4.5005
R73 VDD_TEST.n43 VDD_TEST.n42 4.5005
R74 VDD_TEST.n31 VDD_TEST.n30 4.5005
R75 VDD_TEST.n45 VDD_TEST.n44 4.5005
R76 VDD_TEST.n14 VDD_TEST.n13 4.5005
R77 VDD_TEST.n32 VDD_TEST.n15 4.5005
R78 VDD_TEST.n60 VDD_TEST.n59 4.5005
R79 VDD_TEST.n59 VDD_TEST.n58 4.5005
R80 VDD_TEST.n67 VDD_TEST.n66 4.5005
R81 VDD_TEST.n50 VDD_TEST.n47 4.5005
R82 VDD_TEST.n61 VDD_TEST.n47 4.5005
R83 VDD_TEST.n57 VDD_TEST.n48 4.5005
R84 VDD_TEST.n56 VDD_TEST.n49 4.5005
R85 VDD_TEST.n70 VDD_TEST.n69 4.5005
R86 VDD_TEST.n10 VDD_TEST.n9 4.5005
R87 VDD_TEST.n8 VDD_TEST.n2 4.5005
R88 VDD_TEST.n6 VDD_TEST.n4 4.5005
R89 VDD_TEST.n5 VDD_TEST.n0 4.5005
R90 VDD_TEST.n72 VDD_TEST.n71 4.5005
R91 VDD_TEST.n3 VDD_TEST.n1 4.5005
R92 VDD_TEST.n40 VDD_TEST.n39 3.39658
R93 VDD_TEST.n7 VDD_TEST.n1 2.29888
R94 VDD_TEST.n65 VDD_TEST.n51 2.29108
R95 VDD_TEST.n58 VDD_TEST.n53 2.29092
R96 VDD_TEST.n20 VDD_TEST.n19 2.2908
R97 VDD_TEST.n66 VDD_TEST.n65 2.2505
R98 VDD_TEST.n60 VDD_TEST.n53 2.2505
R99 VDD_TEST.n28 VDD_TEST.n19 2.2505
R100 VDD_TEST.n55 VDD_TEST.n54 2.24103
R101 VDD_TEST.n38 VDD_TEST.n33 2.23986
R102 VDD_TEST.n42 VDD_TEST.n41 2.14771
R103 VDD_TEST.n30 VDD_TEST.n29 1.58092
R104 VDD_TEST.n24 VDD_TEST.n23 1.51224
R105 VDD_TEST.n69 VDD_TEST.n68 0.976829
R106 VDD_TEST VDD_TEST.n73 0.0843636
R107 VDD_TEST.n68 VDD_TEST.n67 0.0503367
R108 VDD_TEST.n6 VDD_TEST.n3 0.0475192
R109 VDD_TEST.n32 VDD_TEST.n31 0.0448558
R110 VDD_TEST.n37 VDD_TEST.n36 0.043463
R111 VDD_TEST.n23 VDD_TEST.n19 0.0432387
R112 VDD_TEST.n28 VDD_TEST.n17 0.0432387
R113 VDD_TEST.n5 VDD_TEST.n2 0.0429038
R114 VDD_TEST.n65 VDD_TEST.n64 0.0412547
R115 VDD_TEST.n53 VDD_TEST.n52 0.0409151
R116 VDD_TEST.n66 VDD_TEST.n49 0.0409151
R117 VDD_TEST.n28 VDD_TEST.n18 0.040299
R118 VDD_TEST.n61 VDD_TEST.n60 0.0402358
R119 VDD_TEST.n73 VDD_TEST.n0 0.0400192
R120 VDD_TEST.n50 VDD_TEST.n48 0.0398962
R121 VDD_TEST.n36 VDD_TEST.n33 0.0304927
R122 VDD_TEST.n24 VDD_TEST.n22 0.0292832
R123 VDD_TEST.n45 VDD_TEST.n14 0.0286595
R124 VDD_TEST.n9 VDD_TEST.n4 0.0252785
R125 VDD_TEST.n60 VDD_TEST.n54 0.0212885
R126 VDD_TEST.n58 VDD_TEST.n54 0.0209489
R127 VDD_TEST.n39 VDD_TEST.n35 0.0193821
R128 VDD_TEST.n44 VDD_TEST.n15 0.0168754
R129 VDD_TEST.n27 VDD_TEST.n26 0.0164885
R130 VDD_TEST.n25 VDD_TEST.n24 0.0154116
R131 VDD_TEST.n59 VDD_TEST.n57 0.0139694
R132 VDD_TEST.n44 VDD_TEST.n43 0.0124914
R133 VDD_TEST.n46 VDD_TEST.n13 0.00875215
R134 VDD_TEST.n39 VDD_TEST.n38 0.00718449
R135 VDD_TEST.n73 VDD_TEST.n72 0.00396154
R136 VDD_TEST.n15 VDD_TEST.n13 0.00359456
R137 VDD_TEST.n43 VDD_TEST.n30 0.00282092
R138 VDD_TEST.n31 VDD_TEST.n14 0.00234049
R139 VDD_TEST.n42 VDD_TEST.n32 0.00234049
R140 VDD_TEST.n22 VDD_TEST.n17 0.00230905
R141 VDD_TEST.n7 VDD_TEST.n6 0.00200948
R142 VDD_TEST.n11 VDD_TEST.n10 0.00165385
R143 VDD_TEST.n72 VDD_TEST.n1 0.00165385
R144 VDD_TEST.n26 VDD_TEST.n16 0.00153152
R145 VDD_TEST.n51 VDD_TEST.n50 0.00150942
R146 VDD_TEST.n20 VDD_TEST.n18 0.00133914
R147 VDD_TEST.n41 VDD_TEST.n40 0.00133394
R148 VDD_TEST.n40 VDD_TEST.n34 0.00133268
R149 VDD_TEST.n64 VDD_TEST.n52 0.00117924
R150 VDD_TEST.n63 VDD_TEST.n62 0.00117924
R151 VDD_TEST.n62 VDD_TEST.n61 0.00117924
R152 VDD_TEST.n10 VDD_TEST.n5 0.00107692
R153 VDD_TEST.n71 VDD_TEST.n2 0.00107692
R154 VDD_TEST.n71 VDD_TEST.n70 0.00107692
R155 VDD_TEST.n70 VDD_TEST.n3 0.00107692
R156 VDD_TEST.n57 VDD_TEST.n56 0.000989796
R157 VDD_TEST.n27 VDD_TEST.n21 0.000886819
R158 VDD_TEST.n29 VDD_TEST.n16 0.000886819
R159 VDD_TEST.n59 VDD_TEST.n47 0.000867347
R160 VDD_TEST.n66 VDD_TEST.n48 0.000839623
R161 VDD_TEST.n63 VDD_TEST.n49 0.000839623
R162 VDD_TEST.n69 VDD_TEST.n12 0.00078481
R163 VDD_TEST.n56 VDD_TEST.n55 0.000744898
R164 VDD_TEST.n35 VDD_TEST.n34 0.000722222
R165 VDD_TEST.n9 VDD_TEST.n8 0.000642405
R166 VDD_TEST.n12 VDD_TEST.n4 0.000642405
R167 VDD_TEST.n67 VDD_TEST.n47 0.000622449
C0 S3 m1_28228_8584# 0.00357f
C1 m1_2167_13969# DN_INPUT 0.30949f
C2 D2 m1_n9031_1076# 0.07976f
C3 S2 m1_20370_13811# 0.37553f
C4 D3 m1_20039_n3680# 0.35806f
C5 D15 OUT1 0.31927f
C6 m1_n1788_23765# m1_20370_13811# 0.01507f
C7 m1_47690_7940# OUT 1.17496f
C8 m1_n1788_23765# PRE_SCALAR 0.00931f
C9 m2_18271_n1063# m3_34855_n14685# 0.07387f
C10 D6 m4_n7940_n28288# 0.10489f
C11 m1_n9031_1076# D1 0.07317f
C12 m1_28228_8584# DN_INPUT 0.08363f
C13 S2 S6 0.02407f
C14 m1_20039_n3680# OUTB 11.4677f
C15 m1_n9031_1076# F_IN 1.66351f
C16 D12 m1_95089_2270# 0.31066f
C17 VDD UP_INPUT 0.72076f
C18 m1_11236_9772# m1_9781_11564# 1.2942f
C19 VDD_TEST m1_47943_864# 0.00638f
C20 m1_37498_n8979# w_37498_n8979# 0.01425f
C21 m1_11236_9772# F_IN 0.00516f
C22 m1_18080_n1660# D3 0.40521f
C23 m1_33953_8519# m2_34756_9620# 0.4176f
C24 m1_20039_n3680# VDD_TEST 0.43952f
C25 m1_48076_2220# m1_43759_5971# 0.24812f
C26 S5 ITAIL_SINK 0.00253f
C27 S2 VDD 1.37696f
C28 VDD m2_34756_9620# 0.06545f
C29 m1_18080_n1660# VCTRL_OBV 0.20378f
C30 D4 D5 0
C31 ITAIL_SINK S1 0.00249f
C32 m1_46331_n7299# m1_48405_n9663# 0.3093f
C33 S6 m1_48405_n9663# 0.01277f
C34 DN_INPUT DN1 0.00694f
C35 m1_95893_16489# OUTB 2.14924f
C36 m1_48076_2220# m1_47690_7940# 0.01557f
C37 S2 m2_26304_11491# 0.08974f
C38 D2 F_IN 0.43206f
C39 ITAIL_SINK VDD_TEST 0.40861f
C40 D6 m1_n9031_1076# 0.11726f
C41 S3 m1_22178_8009# 0.19845f
C42 G_sink_dn G1_2 0
C43 m1_3968_14651# m1_11236_9772# 0.11156f
C44 m1_43759_5971# VSS 0.27314f
C45 D3 m4_n7940_n28288# 0.10672f
C46 m1_18080_n1660# m1_21819_10334# 0.00244f
C47 UP ITAIL_SINK 3.73032f
C48 m1_19888_9897# m1_48405_n9663# 0
C49 G_sink_dn G_source_up 0.00384f
C50 m2_34756_9620# m1_33754_9608# 0
C51 D14 D12 6.25209f
C52 m1_95893_16489# VDD_TEST 7.95439f
C53 m1_18080_n1660# m2_26250_8881# 0.04811f
C54 D0 m1_48405_n9663# 1.35955f
C55 DN_INPUT m1_23689_10953# 0
C56 S6 m1_18490_7270# 0.02316f
C57 D13 D12 2.17017f
C58 LF_OFFCHIP UP_INPUT 0.73864f
C59 m1_18080_n1660# UP 0.57379f
C60 D1 F_IN 1.20989f
C61 m1_9781_11564# F_IN 0.01301f
C62 VCTRL_IN S4 0.02628f
C63 S5 m4_n7940_n28288# 0.40009f
C64 m4_n7940_n28288# S1 0.22882f
C65 m1_12397_5185# m1_10977_7360# 0.00393f
C66 A0 F_IN 0
C67 m1_22178_8009# DN_INPUT 0
C68 D2 m2_18271_n1063# 0
C69 m1_22449_10942# m1_23689_10953# 0.00304f
C70 ITAIL_SINK m1_20370_13811# 1.22933f
C71 S2 LF_OFFCHIP 0.2055f
C72 OUTB m1_56294_5050# 0.03051f
C73 S3 UP_INPUT 0.0027f
C74 m3_78405_n14665# m1_77165_n14593# 0.00467f
C75 m1_43759_5971# m2_34756_9620# 0.87866f
C76 m1_18080_n1660# m1_20370_13811# 0.00114f
C77 m1_48076_2220# m1_95781_18126# 0.37785f
C78 m1_18080_n1660# m1_30473_8717# 0.00285f
C79 D13 VSS 0.02878f
C80 D3 m1_n9031_1076# 0.0764f
C81 m1_3968_14651# m1_9781_11564# 0.25907f
C82 m1_n9031_1076# m1_6386_n8123# 0
C83 UP_INPUT DN 1.53777f
C84 m2_34756_9620# m1_47690_7940# 0.07359f
C85 m5_85331_n528# m1_20039_n3680# 0.11586f
C86 D6 D1 2.53962f
C87 VDD_TEST m1_56294_5050# 0.0365f
C88 D0 m1_20039_n3680# 0.1519f
C89 ITAIL_SRC F_IN 0.55796f
C90 ITAIL_SRC A0 0
C91 m1_41677_12061# VDD_TEST 0.5493f
C92 D7 D9 0.28698f
C93 VDD_TEST DIV_OUT 0.25352f
C94 m1_18080_n1660# S6 0.02103f
C95 m1_18271_9770# S1 0.02208f
C96 UP_INPUT DN_INPUT 0.91151f
C97 S5 m1_n9031_1076# 0.20524f
C98 m1_95893_16489# S4 0.00561f
C99 m1_18080_n1660# m1_27871_5059# 0.09721f
C100 m1_n9031_1076# S1 3.5919f
C101 S2 DN 0.5461f
C102 D15 m1_95089_2270# 0.38618f
C103 m1_43759_5971# m1_48405_n9663# 0.96511f
C104 m1_33768_11014# m1_33754_9608# 0.0019f
C105 VDD ITAIL_SINK 0.45199f
C106 m1_18080_n1660# m1_19888_9897# 0.17568f
C107 D2 D3 7.98711f
C108 S2 DN_INPUT 1.33571f
C109 m1_18080_n1660# D0 0.00466f
C110 m1_95893_16489# m5_85331_n528# 0.00417f
C111 VDD_TEST OUT21 0.29863f
C112 S3 m1_48405_n9663# 0.49735f
C113 S6 m4_n7940_n28288# 0.15914f
C114 SD0_1 G_sink_dn 0
C115 A3 DN_INPUT 0
C116 m1_12397_5185# DN 0.02411f
C117 UP m1_11236_9772# 0.01029f
C118 m1_95781_18126# m2_34756_9620# 0.94214f
C119 m1_20039_n3680# m1_18482_n5517# 0.00679f
C120 m1_43759_5971# m1_47943_864# 0.20142f
C121 D3 F_IN 0.4722f
C122 S3 m1_18490_7270# 0.00169f
C123 D0 m4_n7940_n28288# 0.09392f
C124 D15 D14 3.10442f
C125 m1_n9031_1076# m1_20370_13811# 0.62448f
C126 m1_43759_5971# m1_20039_n3680# 0.65675f
C127 VSS OUT 0.40675f
C128 m1_n9031_1076# PRE_SCALAR 0.19874f
C129 m1_89820_n564# m5_85331_n528# 0.31591f
C130 m1_33768_11014# m1_33300_11005# 0.00761f
C131 A3 m1_2167_13969# 0
C132 m1_47690_7940# m1_20039_n3680# 0.5627f
C133 LF_OFFCHIP ITAIL_SINK 0.03987f
C134 S5 F_IN 2.80644f
C135 m4_n7940_n28288# S7 0.08268f
C136 F_IN S1 1.63732f
C137 m1_n9031_1076# S6 3.46242f
C138 m1_18080_n1660# m1_18482_n5517# 0.00963f
C139 VDD_TEST m1_9781_11564# 0.07327f
C140 VDD_TEST F_IN 0.67456f
C141 VDD m1_41677_12061# 0.42382f
C142 m2_18271_n1063# D3 1.69969f
C143 ITAIL_SINK m1_33300_11005# 0
C144 m1_19888_9897# m1_18271_9770# 0.00648f
C145 m1_n9592_9519# UP_OUT 1.02135f
C146 m1_95893_16489# m1_43759_5971# 0.51429f
C147 UP m1_9781_11564# 0.96163f
C148 D14 m1_20039_n3680# 0.14775f
C149 UP F_IN 0.50113f
C150 D0 m1_n9031_1076# 0.07033f
C151 D13 m1_20039_n3680# 0.33119f
C152 S3 m1_18080_n1660# 1.34237f
C153 m1_95893_16489# m1_47690_7940# 0.64657f
C154 ITAIL_SRC S5 0.22565f
C155 m1_37498_n8979# m3_34855_n14685# 0
C156 ITAIL_SINK DN 0
C157 LF_OFFCHIP m4_n7940_n28288# 0.30607f
C158 m1_95781_18126# VCTRL_IN 0.00118f
C159 D2 S6 0.0108f
C160 m1_3968_14651# VDD_TEST 0.2742f
C161 m1_18080_n1660# DN 0.24891f
C162 ITAIL_SRC VDD_TEST 0.3929f
C163 m1_n9031_1076# S7 0.05765f
C164 F_IN m1_20370_13811# 0.97621f
C165 F_IN PRE_SCALAR 0.02678f
C166 m1_3968_14651# UP 0.14623f
C167 D5 m4_n7940_n28288# 0.09661f
C168 SD2_1 DN_INPUT 0
C169 ITAIL_SRC UP 0.00487f
C170 m1_18080_n1660# DN_INPUT 0.36079f
C171 S3 m4_n7940_n28288# 0.23372f
C172 D0 D2 4.80091f
C173 m1_48076_2220# m2_34756_9620# 0.86781f
C174 m1_2167_13969# ITAIL_SINK 0.13935f
C175 m4_39504_n25347# DIV_OUT 0.32637f
C176 S6 F_IN 0.55847f
C177 m1_18080_n1660# m1_22449_10942# 0
C178 m1_34288_n8979# w_34288_n8979# 0.01456f
C179 m1_n9592_9519# G2_1 0.00331f
C180 m1_n9592_9519# m4_n7940_n28288# 0.18626f
C181 D2 S7 1.10571f
C182 ITAIL_SRC m1_20370_13811# 0.54502f
C183 LF_OFFCHIP m1_n9031_1076# 0.13559f
C184 m1_41677_12061# m1_47690_7940# 0.19475f
C185 m1_95893_16489# m1_95781_18126# 3.41052f
C186 D0 D1 0.00296f
C187 DN_INPUT m4_n7940_n28288# 0.82632f
C188 D0 F_IN 0.34054f
C189 VDD UP1 0.0059f
C190 D13 m1_89820_n564# 0.01395f
C191 D15 D12 0.00161f
C192 D5 m1_n9031_1076# 0.07188f
C193 m1_20039_n3680# OUT 1.31432f
C194 D1 S7 0.61314f
C195 m1_22178_8009# m1_48405_n9663# 0.05898f
C196 S3 m1_n9031_1076# 0.19873f
C197 ITAIL m1_n9592_9519# 0.02931f
C198 m2_26304_11491# UP1 0.00626f
C199 S2 UP_INPUT 0.45735f
C200 F_IN S7 0.80169f
C201 OUTB VDD_TEST 1.2077f
C202 m3_57040_n5286# VDD_TEST 0.01143f
C203 D2 m1_18482_n5517# 0.00262f
C204 S5 VDD_TEST 3.422f
C205 ITAIL_SRC m1_33953_8519# 0.00612f
C206 m1_n9031_1076# m1_n9592_9519# 0.27796f
C207 D0 m2_18271_n1063# 0
C208 D0 D6 0.00254f
C209 ITAIL_SRC VDD 0.40476f
C210 UP S5 0.00145f
C211 m1_11236_9772# DN 0.35544f
C212 UP S1 0.29586f
C213 m1_n9031_1076# DN_INPUT 0.51154f
C214 D5 D2 0.00378f
C215 D12 m1_20039_n3680# 0.12895f
C216 m1_48076_2220# m1_47943_864# 0.00734f
C217 S3 D2 0.02336f
C218 m1_18080_n1660# DN1 0.00482f
C219 m1_32225_5373# VCTRL_OBV 0.01339f
C220 m1_18482_n5517# F_IN 0
C221 m1_11236_9772# DN_INPUT 0.28061f
C222 D6 S7 0.00458f
C223 LF_OFFCHIP F_IN 4.69145f
C224 LF_OFFCHIP A0 0
C225 G_sink_dn A3 0.00247f
C226 S5 m1_20370_13811# 1.87168f
C227 D3 S6 0.05462f
C228 D5 D1 5.39061f
C229 S1 m1_20370_13811# 0.18252f
C230 S2 m1_12397_5185# 0.08217f
C231 VSS m1_47943_864# 0.08533f
C232 D5 F_IN 0.89131f
C233 G1_1 DN_INPUT 0.00429f
C234 G_sink_dn G_sink_up 0.05163f
C235 VDD_TEST m1_20370_13811# 3.44912f
C236 VSS m1_20039_n3680# 0.74785f
C237 S3 F_IN 0.41567f
C238 m1_20370_13811# m1_21819_10334# 0
C239 m1_22178_8009# m1_18080_n1660# 0.6624f
C240 m1_48076_2220# m1_95893_16489# 1.2162f
C241 D0 D3 0
C242 S6 S1 0.72574f
C243 m1_9781_11564# DN 0.36095f
C244 UP m1_20370_13811# 0.7937f
C245 ITAIL_SRC LF_OFFCHIP 3.44203f
C246 DN F_IN 1.38959f
C247 m1_33953_8519# VCTRL_OBV 0.27297f
C248 G1_1 m1_2167_13969# 0
C249 m2_18271_n1063# m1_43759_5971# 0.59738f
C250 m5_85331_n528# OUTB 0.0023f
C251 DN_INPUT m1_9781_11564# 0.27314f
C252 DN_INPUT UP1 0.00137f
C253 DN_INPUT F_IN 0.61297f
C254 D3 S7 0.03801f
C255 D4 m4_n7940_n28288# 0.13062f
C256 D5 D6 0.00364f
C257 VDD S5 0.59352f
C258 UP_INPUT ITAIL_SINK 0.36859f
C259 PRE_SCALAR m1_20370_13811# 0.01163f
C260 m5_85331_n528# VDD_TEST 0.35156f
C261 m1_19888_9897# m1_21819_10334# 0.16799f
C262 m1_3968_14651# DN 0.00341f
C263 OUT1 m5_85331_n528# 0.1289f
C264 m1_18080_n1660# UP_INPUT 0.00344f
C265 ITAIL_SRC DN 0
C266 DN_OUT m4_n7940_n28288# 0.12449f
C267 m1_48076_2220# m1_56294_5050# 0.00623f
C268 S2 ITAIL_SINK 0.75352f
C269 m1_3968_14651# DN_INPUT 1.36182f
C270 VDD UP 1.18562f
C271 D3 m1_18482_n5517# 0.00181f
C272 m1_23396_11515# m2_23388_11515# 0.03573f
C273 S2 m1_18080_n1660# 0.00209f
C274 VDD m2_23388_11515# 0.00862f
C275 m1_20039_n3680# m1_48405_n9663# 6.86957f
C276 m1_43759_5971# D3 1.38239f
C277 A3 ITAIL_SINK 0
C278 D4 m1_n9031_1076# 0.22591f
C279 D15 m1_20039_n3680# 0.25976f
C280 m1_3968_14651# m1_2167_13969# 0.3573f
C281 UP_INPUT m4_n7940_n28288# 0.32797f
C282 m1_43759_5971# VCTRL_OBV 0.20283f
C283 VDD m1_20370_13811# 0.01825f
C284 LF_OFFCHIP S5 5.57603f
C285 m3_57040_n5286# m1_43759_5971# 0.13711f
C286 S3 D3 2.66994f
C287 DN_OUT m1_n9031_1076# 0.52337f
C288 S2 m4_n7940_n28288# 0.16735f
C289 m1_47690_7940# OUTB 0.7098f
C290 m1_95089_2270# VDD_TEST 0.00582f
C291 LF_OFFCHIP VDD_TEST 1.55739f
C292 m1_18080_n1660# m1_48405_n9663# 0.43205f
C293 S3 VCTRL_OBV 0.61889f
C294 OUT1 m1_95089_2270# 0.17722f
C295 m1_43759_5971# VDD_TEST 0.79746f
C296 LF_OFFCHIP UP 0.00317f
C297 S3 S1 0.73404f
C298 VCTRL_OBV DN 0.05969f
C299 m1_47690_7940# VDD_TEST 0.56617f
C300 Q14 m3_78405_n14665# 0.00602f
C301 m1_n9031_1076# UP_INPUT 0.18223f
C302 DN S1 1.22471f
C303 m1_35448_n7135# w_35448_n7135# 0.0097f
C304 UP m1_33300_11005# 0
C305 VDD m1_23396_11515# 0.02227f
C306 UP_INPUT OUT21 0.21497f
C307 S3 UP 0.07103f
C308 D4 D1 0.00168f
C309 LF_OFFCHIP m1_20370_13811# 0.37257f
C310 m1_20039_n3680# m3_78405_n14665# 0.02114f
C311 m1_95893_16489# VCTRL_IN 0.01453f
C312 DN_INPUT S1 0.39474f
C313 S2 m1_n9031_1076# 2.08736f
C314 D0 S7 4.39768f
C315 m1_95893_16489# m1_47943_864# 0
C316 VDD m2_26304_11491# 0.02139f
C317 UP DN 2.75196f
C318 D14 OUT1 0.31693f
C319 VDD_TEST DN_INPUT 0.40799f
C320 m1_95893_16489# m1_20039_n3680# 0.39006f
C321 S3 m1_32225_5373# 0.00364f
C322 m1_n1788_23765# m1_n9031_1076# 0.06828f
C323 S2 m1_11236_9772# 0.04132f
C324 m2_26250_8881# DN_INPUT 0.34176f
C325 D13 OUT1 0.34623f
C326 S3 m1_30473_8717# 0.02453f
C327 UP DN_INPUT 0.00527f
C328 m1_22449_10942# m1_21819_10334# 0.04841f
C329 m2_23388_11515# DN_INPUT 0.00299f
C330 m1_95781_18126# VDD_TEST 6.64542f
C331 m1_2167_13969# VDD_TEST 0.03071f
C332 DN m1_20370_13811# 0.68062f
C333 D8 m3_n2135_50814# 0.03789f
C334 m1_12397_5185# m1_n9031_1076# 0.01339f
C335 m1_30473_8717# DN 0.02265f
C336 m5_85331_n528# m1_95089_2270# 0.24846f
C337 UP_OUT m4_n7940_n28288# 0.29381f
C338 D4 D6 1.83119f
C339 D0 m1_18482_n5517# 0.02473f
C340 S3 S6 6.01122f
C341 m1_89820_n564# m1_20039_n3680# 0.44703f
C342 VDD LF_OFFCHIP 0.42764f
C343 S3 m1_27871_5059# 0.33869f
C344 DN_INPUT m1_20370_13811# 0.33371f
C345 m1_30473_8717# DN_INPUT 0.21926f
C346 UP_INPUT F_IN 0.44454f
C347 D5 D0 5.2028f
C348 m1_18482_n5517# S7 0.02544f
C349 m1_27871_5059# DN 0.01125f
C350 m1_35448_n7135# m3_34855_n14685# 0.00219f
C351 SD2_1 G2_1 0
C352 m1_22449_10942# m1_20370_13811# 0.00907f
C353 OUTB OUT 2.17702f
C354 S2 m1_9781_11564# 0.10206f
C355 VDD m1_47690_7940# 0.01946f
C356 m1_28228_8584# m2_26250_8881# 0.00306f
C357 S2 UP1 0
C358 S2 F_IN 4.84511f
C359 ITAIL UP_OUT 0.00383f
C360 D2 m1_48405_n9663# 0.9924f
C361 D5 S7 0.51602f
C362 VDD_TEST OUT 0.99193f
C363 VDD DN 1.26028f
C364 ITAIL_SRC UP_INPUT 0.34872f
C365 m1_n9031_1076# UP_OUT 0.63601f
C366 m1_95781_18126# S4 0.00965f
C367 D13 m5_85331_n528# 0.11162f
C368 A3 A0 0
C369 m1_10977_7360# DN 0.05973f
C370 VDD DN_INPUT 0.85072f
C371 w_8561_11488# VDD_TEST 0.00156f
C372 m2_26250_8881# DN1 0.00898f
C373 m1_12397_5185# F_IN 0.33482f
C374 S2 ITAIL_SRC 0.18435f
C375 m1_22449_10942# m1_19888_9897# 0.00578f
C376 ITAIL_SRC m2_34756_9620# 0.2202f
C377 m1_18080_n1660# m1_18271_9770# 0.00794f
C378 m1_48076_2220# OUTB 0.48088f
C379 DN_INPUT m2_26304_11491# 0.04122f
C380 G1_2 DN_INPUT 0
C381 m1_95781_18126# m5_85331_n528# 0.00171f
C382 VDD m1_22449_10942# 0.00977f
C383 D2 m1_20039_n3680# 0.50474f
C384 SD0_1 G1_2 0.00579f
C385 m1_n9031_1076# SD01 0.00435f
C386 SD0_1 G_source_up 0
C387 DIV_OUT m4_n7940_n28288# 0.45331f
C388 D12 OUT1 0.25437f
C389 m1_48076_2220# VDD_TEST 1.11484f
C390 LF_OFFCHIP DN 0
C391 m2_18271_n1063# m1_48405_n9663# 4.23175f
C392 m1_22178_8009# m2_26250_8881# 0
C393 D14 m1_95089_2270# 0.38197f
C394 m1_n9031_1076# m4_n7940_n28288# 0.2084f
C395 m1_18080_n1660# D2 0.01418f
C396 LF_OFFCHIP DN_INPUT 0.16476f
C397 D13 m1_95089_2270# 0.42185f
C398 VSS VDD_TEST 0.39448f
C399 S3 DN 0.91813f
C400 S5 UP_INPUT 4.06444f
C401 m5_85331_n528# OUT 0.00153f
C402 ITAIL_SINK m1_9781_11564# 0.01089f
C403 SD0_1 G_source_dn 0
C404 ITAIL_SINK F_IN 0.46802f
C405 m2_34756_9620# VCTRL_OBV 0.75949f
C406 UP_INPUT VDD_TEST 3.8434f
C407 S3 DN_INPUT 0.57431f
C408 ITAIL_SRC m1_33768_11014# 0
C409 m1_95781_18126# m1_43759_5971# 0.15589f
C410 D2 m4_n7940_n28288# 0.11299f
C411 S2 S1 3.08834f
C412 m2_18271_n1063# m1_20039_n3680# 1.92828f
C413 UP UP_INPUT 0.5247f
C414 DN_INPUT DN 0.27464f
C415 m1_95781_18126# m1_47690_7940# 0.68936f
C416 m1_34288_n8979# m3_34855_n14685# 0
C417 m2_34756_9620# VDD_TEST 0.0232f
C418 D3 m1_48405_n9663# 1.27794f
C419 D13 D14 0.00379f
C420 m1_3968_14651# ITAIL_SINK 0.05871f
C421 ITAIL_SRC ITAIL_SINK 4.37505f
C422 S2 UP 2.19777f
C423 D1 m4_n7940_n28288# 0.09973f
C424 VDD m1_23689_10953# 0.00362f
C425 D4 D0 0.00405f
C426 F_IN m4_n7940_n28288# 1.20528f
C427 S2 m2_23388_11515# 0.00504f
C428 UP_INPUT m1_20370_13811# 6.09019f
C429 SD0_1 DN_INPUT 0.00458f
C430 m1_22178_8009# m1_19888_9897# 0.00833f
C431 UP_INPUT PRE_SCALAR 0.00933f
C432 m1_18080_n1660# m2_18271_n1063# 0.40406f
C433 m1_22449_10942# DN_INPUT 0.00667f
C434 DIV_OUT VSUBS 0.10292p
C435 OUT1 VSUBS 7.43644f
C436 D15 VSUBS 8.75996f
C437 D14 VSUBS 14.54914f
C438 D12 VSUBS 12.95872f
C439 D13 VSUBS 14.48438f
C440 D4 VSUBS 8.87264f
C441 D6 VSUBS 10.00578f
C442 D1 VSUBS 16.46583f
C443 D5 VSUBS 18.0025f
C444 D0 VSUBS 23.44626f
C445 S7 VSUBS 17.4254f
C446 D2 VSUBS 23.86893f
C447 D3 VSUBS 14.16061f
C448 VSS VSUBS 20.74252f
C449 OUT VSUBS 28.66372f
C450 OUTB VSUBS 34.0716f
C451 S4 VSUBS 0.18634f
C452 VCTRL_IN VSUBS 0.1868f
C453 S3 VSUBS 23.60126f
C454 S6 VSUBS 24.1483f
C455 VDD VSUBS 31.16521f
C456 S1 VSUBS 40.601f
C457 DN_OUT VSUBS 7.90922f
C458 UP_OUT VSUBS 7.94176f
C459 ITAIL VSUBS 0.12181f
C460 DN_INPUT VSUBS 36.0979f
C461 S2 VSUBS 44.2632f
C462 LF_OFFCHIP VSUBS 52.0764f
C463 F_IN VSUBS 75.7042f
C464 S5 VSUBS 54.2154f
C465 UP_INPUT VSUBS 61.1642f
C466 PRE_SCALAR VSUBS 2.11743f
C467 VDD_TEST VSUBS 82.63209f
C468 D10 VSUBS 1.02779f
C469 D9 VSUBS 1.22082f
C470 D7 VSUBS 2.53095f
C471 D8 VSUBS 2.22888f
C472 m5_85331_n528# VSUBS 39.0689f $ **FLOATING
C473 m4_39504_n25347# VSUBS 7.31794f $ **FLOATING
C474 m4_n7940_n28288# VSUBS 73.5096f $ **FLOATING
C475 m3_78405_n14665# VSUBS 6.32234f $ **FLOATING
C476 m3_67579_n5310# VSUBS 0.50286f $ **FLOATING
C477 m3_57040_n5286# VSUBS 0.91917f $ **FLOATING
C478 m3_34855_n14685# VSUBS 3.35576f $ **FLOATING
C479 m3_n2135_50814# VSUBS 0.49826f $ **FLOATING
C480 m3_n2499_60442# VSUBS 1.00203f $ **FLOATING
C481 m2_18271_n1063# VSUBS 6.2291f $ **FLOATING
C482 m2_26250_8881# VSUBS 0.8047f $ **FLOATING
C483 m2_34756_9620# VSUBS 7.55267f $ **FLOATING
C484 m2_23388_11515# VSUBS 0.08908f $ **FLOATING
C485 m2_26304_11491# VSUBS 0.77748f $ **FLOATING
C486 SD2_1 VSUBS 0.16214f $ **FLOATING
C487 G1_1 VSUBS 0.10123f $ **FLOATING
C488 G1_2 VSUBS 0.07466f $ **FLOATING
C489 SD0_1 VSUBS 0.20854f $ **FLOATING
C490 A3 VSUBS 0.08115f $ **FLOATING
C491 SD01 VSUBS 0.12697f $ **FLOATING
C492 A0 VSUBS 0.14719f $ **FLOATING
C493 OUT11 VSUBS 2.05753f $ **FLOATING
C494 LD1 VSUBS 0.01607f $ **FLOATING
C495 P12 VSUBS 0.29891f $ **FLOATING
C496 Q14 VSUBS 0.63538f $ **FLOATING
C497 Q15 VSUBS 0.46514f $ **FLOATING
C498 m1_77165_n14593# VSUBS 0.3784f $ **FLOATING
C499 OUT01 VSUBS 1.97274f $ **FLOATING
C500 LD0 VSUBS 0.01607f $ **FLOATING
C501 P02 VSUBS 0.13199f $ **FLOATING
C502 m1_19853_n16443# VSUBS 0.0867f $ **FLOATING
C503 Q04 VSUBS 0.34567f $ **FLOATING
C504 Q05 VSUBS 0.21161f $ **FLOATING
C505 m1_25725_n14613# VSUBS 0.6892f $ **FLOATING
C506 Q13 VSUBS 0.32031f $ **FLOATING
C507 Q16 VSUBS 0.41748f $ **FLOATING
C508 Q17 VSUBS 0.27964f $ **FLOATING
C509 Q03 VSUBS 0.35455f $ **FLOATING
C510 Q06 VSUBS 0.20704f $ **FLOATING
C511 Q07 VSUBS 0.16195f $ **FLOATING
C512 m1_48405_n9663# VSUBS 23.5685f $ **FLOATING
C513 m1_37498_n8979# VSUBS 0.12973f $ **FLOATING
C514 m1_34288_n8979# VSUBS 0.13091f $ **FLOATING
C515 Q11 VSUBS 0.41749f $ **FLOATING
C516 Q12 VSUBS 0.32123f $ **FLOATING
C517 m1_57536_n8443# VSUBS 0.48843f $ **FLOATING
C518 m1_28743_n7995# VSUBS 0.18737f $ **FLOATING
C519 Q02 VSUBS 0.17588f $ **FLOATING
C520 m1_6386_n8123# VSUBS 0.29979f $ **FLOATING
C521 m1_46331_n7299# VSUBS 1.48627f $ **FLOATING
C522 m1_35448_n7135# VSUBS 0.09385f $ **FLOATING
C523 m1_18482_n5517# VSUBS 1.64643f $ **FLOATING
C524 m1_89820_n564# VSUBS 1.99451f $ **FLOATING
C525 m1_95089_2270# VSUBS 5.1068f $ **FLOATING
C526 m1_47943_864# VSUBS 2.70222f $ **FLOATING
C527 m1_56294_5050# VSUBS 1.15895f $ **FLOATING
C528 m1_40396_4708# VSUBS 1.37145f $ **FLOATING
C529 m1_43759_5971# VSUBS 21.556f $ **FLOATING
C530 VCTRL_OBV VSUBS 8.66905f $ **FLOATING
C531 m1_48076_2220# VSUBS 11.7553f $ **FLOATING
C532 m1_32225_5373# VSUBS 0.23956f $ **FLOATING
C533 m1_33953_8519# VSUBS 6.36044f $ **FLOATING
C534 m1_33754_9608# VSUBS 0.06176f $ **FLOATING
C535 m1_27871_5059# VSUBS 1.12472f $ **FLOATING
C536 m1_18490_7270# VSUBS 0.25367f $ **FLOATING
C537 m1_22178_8009# VSUBS 2.47609f $ **FLOATING
C538 m1_30473_8717# VSUBS 0.37018f $ **FLOATING
C539 m1_28228_8584# VSUBS 0.56757f $ **FLOATING
C540 DN1 VSUBS 0.04737f $ **FLOATING
C541 m1_19888_9897# VSUBS 1.93488f $ **FLOATING
C542 m1_33768_11014# VSUBS 0.05983f $ **FLOATING
C543 m1_33300_11005# VSUBS 0.06135f $ **FLOATING
C544 m1_41677_12061# VSUBS 4.87445f $ **FLOATING
C545 m1_47690_7940# VSUBS 26.7729f $ **FLOATING
C546 m1_21819_10334# VSUBS 0.5059f $ **FLOATING
C547 m1_18271_9770# VSUBS 0.48844f $ **FLOATING
C548 m1_23689_10953# VSUBS 0.06211f $ **FLOATING
C549 m1_18080_n1660# VSUBS 18.2864f $ **FLOATING
C550 m1_22449_10942# VSUBS 0.61577f $ **FLOATING
C551 UP1 VSUBS 0.032f $ **FLOATING
C552 m1_23396_11515# VSUBS 0.12203f $ **FLOATING
C553 m1_20039_n3680# VSUBS 74.8493f $ **FLOATING
C554 m1_95893_16489# VSUBS 23.1131f $ **FLOATING
C555 m1_95781_18126# VSUBS 24.9518f $ **FLOATING
C556 m1_20370_13811# VSUBS 10.6209f $ **FLOATING
C557 m1_10977_7360# VSUBS 0.48739f $ **FLOATING
C558 m1_12397_5185# VSUBS 1.82663f $ **FLOATING
C559 DN VSUBS 13.0133f $ **FLOATING
C560 m1_n9031_1076# VSUBS 46.7243f $ **FLOATING
C561 m1_n9592_9519# VSUBS 4.03943f $ **FLOATING
C562 G2_1 VSUBS 0.31999f $ **FLOATING
C563 m1_11236_9772# VSUBS 1.96165f $ **FLOATING
C564 UP VSUBS 8.36308f $ **FLOATING
C565 m1_2167_13969# VSUBS 6.02035f $ **FLOATING
C566 m1_9781_11564# VSUBS 6.69756f $ **FLOATING
C567 m1_3968_14651# VSUBS 2.86551f $ **FLOATING
C568 G_sink_dn VSUBS 0.2467f $ **FLOATING
C569 G_sink_up VSUBS 0.10129f $ **FLOATING
C570 G_source_dn VSUBS 0.06868f $ **FLOATING
C571 G_source_up VSUBS 0.06448f $ **FLOATING
C572 ITAIL_SINK VSUBS 10.0148f $ **FLOATING
C573 ITAIL_SRC VSUBS 11.0129f $ **FLOATING
C574 m1_n1788_23765# VSUBS 0.5114f $ **FLOATING
C575 OUT21 VSUBS 7.89769f $ **FLOATING
C576 LD2 VSUBS 0.01607f $ **FLOATING
C577 Q23 VSUBS 0.27666f $ **FLOATING
C578 Q21 VSUBS 0.11603f $ **FLOATING
C579 Q24 VSUBS 0.22417f $ **FLOATING
C580 m1_7285_41464# VSUBS 0.45221f $ **FLOATING
C581 m1_n1113_48238# VSUBS 0.17417f $ **FLOATING
C582 m1_9089_48634# VSUBS 0.08805f $ **FLOATING
C583 Q25 VSUBS 0.24638f $ **FLOATING
C584 Q27 VSUBS 0.11543f $ **FLOATING
C585 Q26 VSUBS 0.24912f $ **FLOATING
C586 Q22 VSUBS 0.26486f $ **FLOATING
C587 w_37498_n8979# VSUBS 0.05606f $ **FLOATING
C588 w_34288_n8979# VSUBS 0.05728f $ **FLOATING
C589 w_35448_n7135# VSUBS 0.03815f $ **FLOATING
C590 w_8561_11488# VSUBS 0.00641f $ **FLOATING
C591 VDD_TEST.n0 VSUBS 0.01221f
C592 VDD_TEST.n1 VSUBS 0.02311f
C593 VDD_TEST.n2 VSUBS 0.00755f
C594 VDD_TEST.n3 VSUBS 0.00836f
C595 VDD_TEST.n4 VSUBS 0.01713f
C596 VDD_TEST.n5 VSUBS 0.00755f
C597 VDD_TEST.n6 VSUBS 0.00852f
C598 VDD_TEST.n7 VSUBS 0.00675f
C599 VDD_TEST.n8 VSUBS 0.02514f
C600 VDD_TEST.n9 VSUBS 0.01724f
C601 VDD_TEST.n10 VSUBS 0
C602 VDD_TEST.n11 VSUBS 0.00487f
C603 VDD_TEST.n12 VSUBS 0
C604 VDD_TEST.n13 VSUBS 0.00998f
C605 VDD_TEST.n14 VSUBS 0.01295f
C606 VDD_TEST.n15 VSUBS 0.01712f
C607 VDD_TEST.n16 VSUBS 0.00125f
C608 VDD_TEST.n17 VSUBS 0.01274f
C609 VDD_TEST.n18 VSUBS 0.01157f
C610 VDD_TEST.n19 VSUBS 0.04265f
C611 VDD_TEST.n20 VSUBS 0.00816f
C612 VDD_TEST.n21 VSUBS 0.02913f
C613 VDD_TEST.n22 VSUBS 0.0128f
C614 VDD_TEST.n23 VSUBS 0.05087f
C615 VDD_TEST.n24 VSUBS 0
C616 VDD_TEST.n25 VSUBS 0.02635f
C617 VDD_TEST.n26 VSUBS 0.01266f
C618 VDD_TEST.n27 VSUBS 0.01256f
C619 VDD_TEST.n28 VSUBS 0.0236f
C620 VDD_TEST.n29 VSUBS 1.43087f
C621 VDD_TEST.n30 VSUBS 1.43007f
C622 VDD_TEST.n31 VSUBS 0.01994f
C623 VDD_TEST.n32 VSUBS 0.01994f
C624 VDD_TEST.n33 VSUBS 0.01346f
C625 VDD_TEST.n34 VSUBS 0
C626 VDD_TEST.n35 VSUBS 0.00666f
C627 VDD_TEST.n36 VSUBS 0.00983f
C628 VDD_TEST.n37 VSUBS 0.00953f
C629 VDD_TEST.n38 VSUBS 0.01542f
C630 VDD_TEST.n39 VSUBS 0.34543f
C631 VDD_TEST.n40 VSUBS 0.17381f
C632 VDD_TEST.n41 VSUBS 0.63596f
C633 VDD_TEST.n42 VSUBS 0.64038f
C634 VDD_TEST.n43 VSUBS 0.01259f
C635 VDD_TEST.n44 VSUBS 0.02494f
C636 VDD_TEST.n45 VSUBS 0.03279f
C637 VDD_TEST.n46 VSUBS 15.7827f
C638 VDD_TEST.n47 VSUBS 0
C639 VDD_TEST.n48 VSUBS 0.00504f
C640 VDD_TEST.n49 VSUBS 0.00517f
C641 VDD_TEST.n50 VSUBS 0.00509f
C642 VDD_TEST.n51 VSUBS 0.0119f
C643 VDD_TEST.n52 VSUBS 0.00521f
C644 VDD_TEST.n53 VSUBS 0.02534f
C645 VDD_TEST.n54 VSUBS 0
C646 VDD_TEST.n55 VSUBS 0.00896f
C647 VDD_TEST.n56 VSUBS 0
C648 VDD_TEST.n57 VSUBS 0.01361f
C649 VDD_TEST.n58 VSUBS 0.0156f
C650 VDD_TEST.n59 VSUBS 0.01349f
C651 VDD_TEST.n60 VSUBS 0.01012f
C652 VDD_TEST.n61 VSUBS 0.00512f
C653 VDD_TEST.n62 VSUBS 0
C654 VDD_TEST.n63 VSUBS 0
C655 VDD_TEST.n64 VSUBS 0.00525f
C656 VDD_TEST.n65 VSUBS 0.02665f
C657 VDD_TEST.n66 VSUBS 0.00517f
C658 VDD_TEST.n67 VSUBS 0.04871f
C659 VDD_TEST.n68 VSUBS 14.2081f
C660 VDD_TEST.n69 VSUBS 0.70404f
C661 VDD_TEST.n70 VSUBS 0
C662 VDD_TEST.n71 VSUBS 0
C663 VDD_TEST.n72 VSUBS 0
C664 VDD_TEST.n73 VSUBS 0.01488f
C665 S3.n0 VSUBS 0.10766f
C666 S3.n1 VSUBS 0.04182f
C667 S3.n2 VSUBS 0.00145f
C668 S3.n3 VSUBS 0.05704f
C669 S3.n4 VSUBS 0.26411f
C670 S3.n5 VSUBS 0.08049f
C671 S3.n6 VSUBS 0.03436f
C672 S3.n7 VSUBS 0.04645f
C673 S3.n8 VSUBS 0.05093f
C674 S3.n9 VSUBS 2.43678f
C675 S3.n10 VSUBS 2.55993f
C676 S3.n11 VSUBS 0.07368f
C677 S3.n12 VSUBS 0.05623f
C678 S3.n13 VSUBS 2.53741f
C679 S3.n14 VSUBS 2.54392f
C680 S3.n15 VSUBS 0.03719f
C681 S3.n16 VSUBS 0.03636f
C682 S3.n17 VSUBS 0.19204f
C683 S3.n18 VSUBS 0.07547f
C684 S3.n19 VSUBS 0.36737f
C685 D3.n0 VSUBS 0.00646f
C686 D3.n1 VSUBS 0.08957f
C687 D3.n2 VSUBS 0.03615f
C688 D3.n3 VSUBS 0.04704f
C689 D3.n4 VSUBS 0.02944f
C690 D3.n5 VSUBS 0.04478f
C691 D3.n6 VSUBS 0.10474f
C692 D3.n7 VSUBS 0.03228f
C693 D3.n8 VSUBS 12.7798f
C694 D3.n9 VSUBS 0.03879f
C695 D3.n10 VSUBS 0.03308f
C696 D3.n11 VSUBS 0.11972f
.ends
