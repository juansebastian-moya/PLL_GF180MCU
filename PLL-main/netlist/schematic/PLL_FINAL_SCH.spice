** sch_path: /home/moya/Documents/EuroCDP/ms_IPs/PLL/PLL-main/schematic/xschem/PLL_FINAL_SCH.sch
.subckt PLL_FINAL_SCH VDD_TEST D12 D0 UP_INPUT D13 D1 DN_INPUT VSS D14 D2 PRE_SCALAR UP_OUT D15 D3 F_IN DN_OUT D4 ITAIL DIV_OUT D5
+ S1 S6 D6 VCTRL_IN D7 S2 D8 S3 OUT D9 OUTB S4 LF_OFFCHIP D10 S5 S7 OUT1 VDD
*.PININFO UP_INPUT:I DN_INPUT:I UP_OUT:O DN_OUT:O ITAIL:I OUT:O OUTB:B VDD:B VSS:B PRE_SCALAR:O F_IN:I DIV_OUT:O S1:I S6:I S2:I
*+ S3:I VCTRL_IN:I S4:I S5:I LF_OFFCHIP:I D0:I D1:I D2:I D3:I D4:I D5:I D6:I D7:I D8:I D9:I D10:I D12:I D13:I D14:I D15:I OUT1:O S7:I
*+ VDD_TEST:B
x25 VDD_TEST ITAIL ITAIL_SRC ITAIL_SINK VSS Current_Mirror_Top_s
x18 VDD LD2 VSS Q21 VSS Q22 VSS D10 Q23 Q24 D9 D8 Q25 D7 Q26 Q27 F_IN VSS net4 P22 7b_divider
x17 VDD LD0 D6 Q01 D5 Q02 D4 D3 Q03 Q04 D2 D1 Q05 D0 Q06 Q07 IN_DIV VSS OUT01 P02 7b_divider
x28 VDD LD1 VSS Q11 VSS Q12 VSS D15 Q13 Q14 D14 D13 Q15 D12 Q16 Q17 OUT_D VSS OUT11 P12 7b_divider
x13 VSS VDD_TEST PRE_SCALAR net4 Tappered-Buffer_1
x14 VSS VDD_TEST UP_OUT net8 Tappered-Buffer_1
x15 VSS VDD_TEST OUT net1 Tappered-Buffer_1
x19 VSS VDD_TEST OUTB net7 Tappered-Buffer_1
x20 VSS VDD_TEST OUT_D net7 Tappered-Buffer_1
x21 VSS VDD_TEST DN_OUT net10 Tappered-Buffer_1
x22 VSS VDD_TEST DIV_OUT OUT01 Tappered-Buffer_1
x23 VSS VDD_TEST OUT1 OUT11 Tappered-Buffer_1
x2 VDD VSS net4 F_IN S1 net5 A_MUX
x3 VDD VSS OUT01 VSS S6 net6 A_MUX
x4 VDD VSS net3 DN_INPUT S3 DN A_MUX
x5 VDD VSS net2 UP_INPUT S2 UP A_MUX
x6 VDD VSS MUFTA2 VCTRL_IN S4 VCTRL_OBV A_MUX
x12 VDD VSS MUFTA LF_OFFCHIP S5 MUFTA2 A_MUX
x1 net2 net3 VDD VSS net5 net6 PFD_ver_2
x8 VDD ITAIL_SINK ITAIL_SRC MUFTA2 DN UP VSS CP
x7 VDD VSS VCTRL_OBV VDD net1 net7 VCO_1
x11 net9 VSS cap_240p
x9 MUFTA VDD net9 Res_74k
x10 MUFTA VSS cap_11p
x24 VDD VSS OUT_D F_IN S7 IN_DIV A_MUX
x16 VSS VDD_TEST net8 UP INV_1
x26 VSS VDD_TEST net10 DN INV_1
.ends

* expanding   symbol:  Current_Mirror_Top_s.sym # of pins=5
** sym_path: /home/moya/Documents/EuroCDP/ms_IPs/PLL/PLL-main/schematic/xschem/Current_Mirror_Top_s.sym
** sch_path: /home/moya/Documents/EuroCDP/ms_IPs/PLL/PLL-main/schematic/xschem/Current_Mirror_Top_s.sch
.subckt Current_Mirror_Top_s VDD ITAIL ITAIL_SRC ITAIL_SINK VSS
*.PININFO ITAIL:I VDD:B VSS:B ITAIL_SRC:O ITAIL_SINK:O
M1 net2 ITAIL net1 VSS nfet_03v3 L=0.5u W=20u nf=1 m=1
M2 net1 net5 VSS VSS nfet_03v3 L=0.5u W=20u nf=1 m=1
M7 net2 net2 net3 VDD pfet_03v3 L=0.5u W=20u nf=1 m=1
M8 net3 net3 VDD VDD pfet_03v3 L=0.5u W=20u nf=1 m=1
M9 G_sink_up net2 net4 VDD pfet_03v3 L=0.5u W=4u nf=1 m=1
M10 net4 net3 VDD VDD pfet_03v3 L=0.5u W=4u nf=1 m=1
M11 G_sink_up G_sink_up G_sink_dn VSS nfet_03v3 L=0.5u W=4.8u nf=1 m=1
M12 G_sink_dn G_sink_dn VSS VSS nfet_03v3 L=0.5u W=4.8u nf=1 m=1
M3 ITAIL ITAIL net5 VSS nfet_03v3 L=0.5u W=20u nf=1 m=1
M4 net5 net5 VSS VSS nfet_03v3 L=0.5u W=20u nf=1 m=1
M5 G_source_dn G_sink_up net6 VSS nfet_03v3 L=0.5u W=4.8u nf=1 m=1
M6 net6 G_sink_dn VSS VSS nfet_03v3 L=0.5u W=4.8u nf=1 m=1
M13 G_source_dn G_source_dn G_source_up VDD pfet_03v3 L=0.5u W=4.8u nf=1 m=1
M14 G_source_up G_source_up VDD VDD pfet_03v3 L=0.5u W=4.8u nf=1 m=1
M15 ITAIL_SINK G_sink_up net7 VSS nfet_03v3 L=0.5u W=4.8u nf=1 m=1
M16 net7 G_sink_dn VSS VSS nfet_03v3 L=0.5u W=4.8u nf=1 m=1
M17 ITAIL_SRC G_source_dn net8 VDD pfet_03v3 L=0.5u W=4.8u nf=1 m=1
M18 net8 G_source_up VDD VDD pfet_03v3 L=0.5u W=4.8u nf=1 m=1
.ends

* expanding   symbol:  7b_divider.sym # of pins=20
** sym_path: /home/moya/Documents/EuroCDP/ms_IPs/PLL/PLL-main/schematic/xschem/7b_divider.sym
** sch_path: /home/moya/Documents/EuroCDP/ms_IPs/PLL/PLL-main/schematic/xschem/7b_divider.sch
.subckt 7b_divider VDD LD D2_7 Q1 D2_6 Q2 D2_5 D2_4 Q3 Q4 D2_3 D2_2 Q5 D2_1 Q6 Q7 CLK VSS OUT1 P2
*.PININFO VDD:B VSS:B D2_1:I CLK:I D2_2:I D2_3:I D2_4:I D2_5:I D2_6:I D2_7:I LD:O Q1:O Q2:O Q3:O Q4:O Q5:O Q6:O Q7:O P2:O OUT1:O
x4 VDD Q2 b D2_3 VSS XNOR
x5 VDD Q1 a D2_2 VSS XNOR
x6 VDD Q3 c D2_4 VSS XNOR
x7 VDD net1 a b c VSS 3_inp_AND
x2 VDD Q4 d D2_5 VSS XNOR
x3 VDD Q5 e D2_6 VSS XNOR
x9 VDD Q6 f D2_7 VSS XNOR
x10 VDD Q7 g D2_1 VSS XNOR
x15 VDD net4 net1 net2 net3 VSS 3_inp_AND
x16 VDD P0 P2 net5 VSS OR
x17 net5 VDD OUT3 VSS div_by_2
x1 LD VDD Q6 Q4 Q2 Q5 Q1 Q3 Q7 D2_7 D2_6 D2_3 D2_5 D2_2 D2_4 D2_1 CLK VSS 7b_counter_new
x8 CLK VDD LD P0 VSS DFF
x14 VDD Q2 j2 D2_3 VSS XNOR
x18 VDD Q1 j1 D2_2 VSS XNOR
x19 VDD Q3 j3 D2_4 VSS XNOR
x20 VDD Q4 j4 D2_5 VSS XNOR
x21 VDD Q5 j5 D2_6 VSS XNOR
x22 VDD Q6 j6 D2_7 VSS XNOR
x23 VDD Q7 j7 D2_1B VSS XNOR
x24 VDD D2_1 D2_1B VSS inverter
x25 VDD net6 j1 j2 j3 VSS 3_inp_AND
x26 VDD net9 net6 net7 net8 VSS 3_inp_AND
x29 CLK VDD net9 P3 VSS ned_DFF
x30 VDD P0 P3 net10 VSS OR
x31 net10 VDD OUT2 VSS div_by_2
x32 VDD D2_1 OUT3 OUT1 VSS OUT2 MUX
x13 CLK VDD net4 P2 VSS DFF
x33 VDD net7 j4 j5 VSS AND
x27 VDD net8 j6 j7 VSS AND
x11 VDD net2 d e VSS AND
x12 VDD net3 f g VSS AND
.ends

* expanding   symbol:  Tappered-Buffer_1.sym # of pins=4
** sym_path: /home/moya/Documents/EuroCDP/ms_IPs/PLL/PLL-main/schematic/xschem/Tappered-Buffer_1.sym
** sch_path: /home/moya/Documents/EuroCDP/ms_IPs/PLL/PLL-main/schematic/xschem/Tappered-Buffer_1.sch
.subckt Tappered-Buffer_1 VSS VDD OUT IN
*.PININFO VDD:B VSS:B IN:I OUT:O
M3 net1 IN VSS VSS nfet_03v3 L=0.5u W=5.6u nf=1 m=1
M4 net1 IN VDD VDD pfet_03v3 L=0.5u W=11.2u nf=1 m=1
M1 net2 net1 VSS VSS nfet_03v3 L=0.5u W=22.4u nf=1 m=1
M2 net2 net1 VDD VDD pfet_03v3 L=0.5u W=44.8u nf=1 m=1
M5 OUT net2 VSS VSS nfet_03v3 L=0.5u W=89.6u nf=1 m=1
M6 OUT net2 VDD VDD pfet_03v3 L=0.5u W=89.6u nf=1 m=1
M7 OUT net2 VDD VDD pfet_03v3 L=0.5u W=89.6u nf=1 m=1
M8 VSS VSS VSS VSS nfet_03v3 L=0.5u W=39.2u nf=1 m=1
.ends

* expanding   symbol:  A_MUX.sym # of pins=6
** sym_path: /home/moya/Documents/EuroCDP/ms_IPs/PLL/PLL-main/schematic/xschem/A_MUX.sym
** sch_path: /home/moya/Documents/EuroCDP/ms_IPs/PLL/PLL-main/schematic/xschem/A_MUX.sch
.subckt A_MUX VDD VSS IN1 IN2 SEL OUT
*.PININFO VSS:B IN1:I IN2:I SEL:I OUT:O VDD:B
x1 OUT VDD VSS IN2 SEL TR_Gate
x2 OUT VDD VSS IN1 net1 TR_Gate
x3 VSS VDD net1 SEL INV_1
.ends

* expanding   symbol:  PFD_ver_2.sym # of pins=6
** sym_path: /home/moya/Documents/EuroCDP/ms_IPs/PLL/PLL-main/schematic/xschem/PFD_ver_2.sym
** sch_path: /home/moya/Documents/EuroCDP/ms_IPs/PLL/PLL-main/schematic/xschem/PFD_ver_2.sch
.subckt PFD_ver_2 up down VDD VSS FIN FDIV
*.PININFO VDD:B VSS:B FIN:I FDIV:I up:O down:O
M1 A x1b net2 VSS nfet_03v3 L=0.5u W=1u nf=1 m=1
M4 A FIN VDD VDD pfet_03v3 L=0.5u W=1u nf=1 m=1
M5 x1 A VDD VDD pfet_03v3 L=0.5u W=5.5u nf=1 m=1
M6 x1 x1 net3 VDD pfet_03v3 L=0.5u W=1u nf=1 m=1
M7 net3 x2 VDD VDD pfet_03v3 L=0.5u W=1u nf=1 m=1
M8 x3 x1 VDD VDD pfet_03v3 L=0.5u W=2.5u nf=1 m=1
M9 net2 x2b VSS VSS nfet_03v3 L=0.5u W=1u nf=1 m=1
M11 x1 FIN net1 VSS nfet_03v3 L=0.5u W=1u nf=1 m=1
M12 net1 A VSS VSS nfet_03v3 L=0.5u W=1u nf=1 m=1
M13 x3 x1 net4 VSS nfet_03v3 L=0.5u W=1.5u nf=1 m=1
M14 net4 x1 VSS VSS nfet_03v3 L=0.5u W=1.5u nf=1 m=1
x1 VSS VDD x1b x1 GF_INV
M15 B x1b net6 VSS nfet_03v3 L=0.5u W=1u nf=1 m=1
M18 B FDIV VDD VDD pfet_03v3 L=0.5u W=1u nf=1 m=1
M19 x2 B VDD VDD pfet_03v3 L=0.5u W=5.5u nf=1 m=1
M20 x2 x2 net7 VDD pfet_03v3 L=0.5u W=1u nf=1 m=1
M21 net7 x1 VDD VDD pfet_03v3 L=0.5u W=1u nf=1 m=1
M22 net8 x2 VDD VDD pfet_03v3 L=0.5u W=2.5u nf=1 m=1
M23 net6 x2b VSS VSS nfet_03v3 L=0.5u W=1u nf=1 m=1
M25 x2 FDIV net5 VSS nfet_03v3 L=0.5u W=1u nf=1 m=1
M26 net5 B VSS VSS nfet_03v3 L=0.5u W=1u nf=1 m=1
M27 net8 x2 net9 VSS nfet_03v3 L=0.5u W=1.5u nf=1 m=1
M28 net9 x2 VSS VSS nfet_03v3 L=0.5u W=1.5u nf=1 m=1
x2 VSS VDD x2b x2 GF_INV
M29 net8 x1b VSS VSS nfet_03v3 L=0.5u W=1.5u nf=1 m=1
M30 x3 x2b VSS VSS nfet_03v3 L=0.5u W=1.5u nf=1 m=1
x3 VDD x3 up VSS Buffer_V_2
x4 VDD net8 down VSS Buffer_V_2
.ends

* expanding   symbol:  CP.sym # of pins=7
** sym_path: /home/moya/Documents/EuroCDP/ms_IPs/PLL/PLL-main/schematic/xschem/CP.sym
** sch_path: /home/moya/Documents/EuroCDP/ms_IPs/PLL/PLL-main/schematic/xschem/CP.sch
.subckt CP VDD ITAIL ITAIL1 VCTRL UP down VSS
*.PININFO UP:I down:I VCTRL:B VDD:B VSS:B ITAIL1:B ITAIL:B
M1 net1 net2 VDD VDD pfet_03v3 L=0.56u W=2.8u nf=1 m=1
M3 VCTRL ITAIL net1 VDD pfet_03v3 L=0.56u W=2.24u nf=1 m=1
M2 ITAIL ITAIL VDD VDD pfet_03v3 L=0.56u W=2.24u nf=1 m=1
M6 ITAIL1 ITAIL1 VSS VSS nfet_03v3 L=0.56u W=1.12u nf=1 m=1
M5 VCTRL ITAIL1 net3 VSS nfet_03v3 L=0.56u W=1.12u nf=1 m=1
M4 net3 down VSS VSS nfet_03v3 L=0.56u W=1.4u nf=1 m=1
M7 net2 UP VSS VSS nfet_03v3 L=0.56u W=0.56u nf=1 m=1
M8 net2 UP VDD VDD pfet_03v3 L=0.56u W=1.12u nf=1 m=1
.ends

* expanding   symbol:  VCO_1.sym # of pins=6
** sym_path: /home/moya/Documents/EuroCDP/ms_IPs/PLL/PLL-main/schematic/xschem/VCO_1.sym
** sch_path: /home/moya/Documents/EuroCDP/ms_IPs/PLL/PLL-main/schematic/xschem/VCO_1.sch
.subckt VCO_1 VDD VSS VCTRL VCTRL2 OUT OUTB
*.PININFO OUT:O VDD:B VSS:B OUTB:O VCTRL:I VCTRL2:I
x1 VDD VSS net5 net6 VCTRL VCTRL2 net1 net2 DelayCell_1
x2 VDD VSS net7 net8 VCTRL VCTRL2 out1 outb1 DelayCell_1
x3 VSS VDD net7 net1 INV_1
x4 VSS VDD net8 net2 INV_1
x5 VSS VDD net4 out1 INV_1
x6 VSS VDD net5 net4 INV_1
x7 VSS VDD net3 outb1 INV_1
x8 VSS VDD net6 net3 INV_1
x9 VDD VSS net6 OUTB OUT OUTB D-FF
.ends

* expanding   symbol:  cap_240p.sym # of pins=2
** sym_path: /home/moya/Documents/EuroCDP/ms_IPs/PLL/PLL-main/schematic/xschem/cap_240p.sym
** sch_path: /home/moya/Documents/EuroCDP/ms_IPs/PLL/PLL-main/schematic/xschem/cap_240p.sch
.subckt cap_240p P M
*.PININFO P:B M:B
XC2 P M cap_mim_2f0_m4m5_noshield c_width=31e-6 c_length=29e-6 m=132
.ends

* expanding   symbol:  Res_74k.sym # of pins=3
** sym_path: /home/moya/Documents/EuroCDP/ms_IPs/PLL/PLL-main/schematic/xschem/Res_74k.sym
** sch_path: /home/moya/Documents/EuroCDP/ms_IPs/PLL/PLL-main/schematic/xschem/Res_74k.sch
.subckt Res_74k P VDD M
*.PININFO P:B VDD:B M:B
XR1 M P VDD ppolyf_u r_width=1.1e-6 r_length=195e-6 m=1
XR2 VDD VDD VDD ppolyf_u r_width=48.4e-6 r_length=2.6e-6 m=1
.ends

* expanding   symbol:  cap_11p.sym # of pins=2
** sym_path: /home/moya/Documents/EuroCDP/ms_IPs/PLL/PLL-main/schematic/xschem/cap_11p.sym
** sch_path: /home/moya/Documents/EuroCDP/ms_IPs/PLL/PLL-main/schematic/xschem/cap_11p.sch
.subckt cap_11p P M
*.PININFO P:B M:B
XC2 P M cap_mim_2f0_m4m5_noshield c_width=30e-6 c_length=30e-6 m=6
.ends

* expanding   symbol:  INV_1.sym # of pins=4
** sym_path: /home/moya/Documents/EuroCDP/ms_IPs/PLL/PLL-main/schematic/xschem/INV_1.sym
** sch_path: /home/moya/Documents/EuroCDP/ms_IPs/PLL/PLL-main/schematic/xschem/INV_1.sch
.subckt INV_1 VSS VDD OUT IN
*.PININFO VDD:B VSS:B IN:I OUT:O
M1 OUT IN VSS VSS nfet_03v3 L=0.5u W=2u nf=1 m=1
M2 OUT IN VDD VDD pfet_03v3 L=0.5u W=4u nf=1 m=1
.ends

* expanding   symbol:  XNOR.sym # of pins=5
** sym_path: /home/moya/Documents/EuroCDP/ms_IPs/PLL/PLL-main/schematic/xschem/XNOR.sym
** sch_path: /home/moya/Documents/EuroCDP/ms_IPs/PLL/PLL-main/schematic/xschem/XNOR.sch
.subckt XNOR VDD A OUT B VSS
*.PININFO VDD:B VSS:B A:I B:I OUT:O
M1 OUT A net3 VSS nfet_03v3 L=0.56u W=1.12u nf=1 m=1
M2 net1 A VDD VDD pfet_03v3 L=0.56u W=2.24u nf=1 m=1
M3 net2 A_bar VDD VDD pfet_03v3 L=0.56u W=2.24u nf=1 m=1
M4 OUT B net1 VDD pfet_03v3 L=0.56u W=2.24u nf=1 m=1
M5 OUT B_bar net2 VDD pfet_03v3 L=0.56u W=2.24u nf=1 m=1
M6 OUT A_bar net4 VSS nfet_03v3 L=0.56u W=1.12u nf=1 m=1
M7 net3 B_bar VSS VSS nfet_03v3 L=0.56u W=1.12u nf=1 m=1
M8 net4 B VSS VSS nfet_03v3 L=0.56u W=1.12u nf=1 m=1
x1 VDD A A_bar VSS inverter_1
x2 VDD B B_bar VSS inverter_1
.ends

* expanding   symbol:  3_inp_AND.sym # of pins=6
** sym_path: /home/moya/Documents/EuroCDP/ms_IPs/PLL/PLL-main/schematic/xschem/3_inp_AND.sym
** sch_path: /home/moya/Documents/EuroCDP/ms_IPs/PLL/PLL-main/schematic/xschem/3_inp_AND.sch
.subckt 3_inp_AND VDD VOUT A B C VSS
*.PININFO VSS:B VDD:B A:I B:I C:I VOUT:O
M1 net3 A net1 VSS nfet_03v3 L=0.56u W=3.36u nf=1 m=1
M2 net3 C VDD VDD pfet_03v3 L=0.56u W=2.24u nf=1 m=1
M3 net1 B net2 VSS nfet_03v3 L=0.56u W=3.36u nf=1 m=1
M4 net2 C VSS VSS nfet_03v3 L=0.56u W=3.36u nf=1 m=1
M5 net3 B VDD VDD pfet_03v3 L=0.56u W=2.24u nf=1 m=1
M6 net3 A VDD VDD pfet_03v3 L=0.56u W=2.24u nf=1 m=1
M7 VOUT net3 VDD VDD pfet_03v3 L=0.56u W=2.24u nf=1 m=1
M8 VOUT net3 VSS VSS nfet_03v3 L=0.56u W=1.12u nf=1 m=1
M9 VOUT VOUT VOUT VDD pfet_03v3 L=0.56u W=1.12u nf=1 m=1
M10 VDD VDD VDD VDD pfet_03v3 L=0.56u W=1.12u nf=1 m=1
.ends

* expanding   symbol:  OR.sym # of pins=5
** sym_path: /home/moya/Documents/EuroCDP/ms_IPs/PLL/PLL-main/schematic/xschem/OR.sym
** sch_path: /home/moya/Documents/EuroCDP/ms_IPs/PLL/PLL-main/schematic/xschem/OR.sch
.subckt OR VDD A B VOUT VSS
*.PININFO VSS:B VDD:B A:I B:I VOUT:O
M1 net1 A VSS VSS nfet_03v3 L=0.56u W=1.12u nf=1 m=1
M2 net1 B net2 VDD pfet_03v3 L=0.56u W=4.48u nf=1 m=1
M3 net1 B VSS VSS nfet_03v3 L=0.56u W=1.12u nf=1 m=1
M6 net2 A VDD VDD pfet_03v3 L=0.56u W=4.48u nf=1 m=1
M4 VOUT net1 VDD VDD pfet_03v3 L=0.56u W=2.24u nf=1 m=1
M5 VOUT net1 VSS VSS nfet_03v3 L=0.56u W=1.12u nf=1 m=1
.ends

* expanding   symbol:  div_by_2.sym # of pins=4
** sym_path: /home/moya/Documents/EuroCDP/ms_IPs/PLL/PLL-main/schematic/xschem/div_by_2.sym
** sch_path: /home/moya/Documents/EuroCDP/ms_IPs/PLL/PLL-main/schematic/xschem/div_by_2.sch
.subckt div_by_2 CLK VDD Q VSS
*.PININFO VDD:B VSS:B Q:O CLK:I
x1 VDD CLKB VSS net2 net1 tg
x3 VDD CLK VSS net2 net5 tg
x4 VDD CLK VSS net1 net3 tg
x5 VDD CLKB VSS net1 net4 tg
x2 VDD net2 net3 VSS inverter
x6 VDD net1 Q VSS inverter
x7 VDD Q net4 VSS inverter
x8 VDD net3 net5 VSS inverter
x9 VDD CLK CLKB VSS inverter
.ends

* expanding   symbol:  7b_counter_new.sym # of pins=18
** sym_path: /home/moya/Documents/EuroCDP/ms_IPs/PLL/PLL-main/schematic/xschem/7b_counter_new.sym
** sch_path: /home/moya/Documents/EuroCDP/ms_IPs/PLL/PLL-main/schematic/xschem/7b_counter_new.sch
.subckt 7b_counter_new LD VDD Q6 Q4 Q2 Q5 Q1 Q3 Q7 D2_7 D2_6 D2_3 D2_5 D2_2 D2_4 D2_1 G-CLK VSS
*.PININFO VDD:B VSS:B Q3:O Q1:O D2_1:I D2_2:I D2_3:I G-CLK:I Q2:O LD:O D2_4:I Q4:O D2_5:I Q5:O Q6:O D2_6:I Q7:O D2_7:I
x6 VDD net3 net2 net1 VSS NAND
x9 VDD Q1 Q2 Q3 net9 VSS 3_inp_NOR
x7 G-CLK VDD net3 net2 VSS DFF
x8 VDD net2 LD VSS inverter
x1 VDD LD3 D2_1 Q1 a a VSS G-CLK G-CLK MOD_DFF_latest
x3 VDD LD3 D2_2 Q2 b b VSS Q1 G-CLK MOD_DFF_latest
x4 VDD LD1 D2_3 Q3 c c VSS Q2 G-CLK MOD_DFF_latest
x2 VDD LD1 D2_4 Q4 d d VSS Q3 G-CLK MOD_DFF_latest
x10 VDD LD2 D2_5 Q5 e e VSS Q4 G-CLK MOD_DFF_latest
x11 VDD LD1 D2_6 Q6 f f VSS Q5 G-CLK MOD_DFF_latest
x12 VDD LD2 D2_7 Q7 g g VSS Q6 G-CLK MOD_DFF_latest
x5 VDD net1 net5 net4 net9 VSS 3_inp_AND
x13 VDD Q4 Q5 net5 VSS NOR
x14 VDD Q6 Q7 net4 VSS NOR
M4 net6 LD VDD VDD pfet_03v3 L=0.56u W=6.72u nf=1 m=1
M5 net6 LD VSS VSS nfet_03v3 L=0.56u W=3.36u nf=1 m=1
M1 LD1 net6 VSS VSS nfet_03v3 L=0.56u W=3.36u nf=1 m=1
M2 LD1 net6 VDD VDD pfet_03v3 L=0.56u W=6.72u nf=1 m=1
M3 net7 LD VSS VSS nfet_03v3 L=0.56u W=3.36u nf=1 m=1
M6 net7 LD VDD VDD pfet_03v3 L=0.56u W=6.72u nf=1 m=1
M7 LD2 net7 VDD VDD pfet_03v3 L=0.56u W=6.72u nf=1 m=1
M8 net8 LD VDD VDD pfet_03v3 L=0.56u W=6.72u nf=1 m=1
M9 LD3 net8 VDD VDD pfet_03v3 L=0.56u W=6.72u nf=1 m=1
M10 LD2 net7 VSS VSS nfet_03v3 L=0.56u W=3.36u nf=1 m=1
M11 net8 LD VSS VSS nfet_03v3 L=0.56u W=3.36u nf=1 m=1
M12 LD3 net8 VSS VSS nfet_03v3 L=0.56u W=3.36u nf=1 m=1
.ends

* expanding   symbol:  DFF.sym # of pins=5
** sym_path: /home/moya/Documents/EuroCDP/ms_IPs/PLL/PLL-main/schematic/xschem/DFF.sym
** sch_path: /home/moya/Documents/EuroCDP/ms_IPs/PLL/PLL-main/schematic/xschem/DFF.sch
.subckt DFF CLK VDD D Q VSS
*.PININFO D:I VDD:B VSS:B Q:O CLK:I
x2 VDD net1 net2 VSS inverter
x6 VDD net3 Q VSS inverter
x7 VDD Q net4 VSS inverter
x8 VDD net2 net5 VSS inverter
x9 VDD CLK CLKB VSS inverter
x1 VDD CLKB VSS net1 D tg
x3 VDD CLK VSS net3 net2 tg
x4 VDD CLK VSS net1 net5 tg
x5 VDD CLKB VSS net3 net4 tg
.ends

* expanding   symbol:  inverter.sym # of pins=4
** sym_path: /home/moya/Documents/EuroCDP/ms_IPs/PLL/PLL-main/schematic/xschem/inverter.sym
** sch_path: /home/moya/Documents/EuroCDP/ms_IPs/PLL/PLL-main/schematic/xschem/inverter.sch
.subckt inverter VDD VIN VOUT VSS
*.PININFO VDD:B VIN:I VOUT:O VSS:B
M4 VOUT VIN VDD VDD pfet_03v3 L=0.56u W=4.48u nf=1 m=1
M5 VOUT VIN VSS VSS nfet_03v3 L=0.56u W=2.24u nf=1 m=1
.ends

* expanding   symbol:  ned_DFF.sym # of pins=5
** sym_path: /home/moya/Documents/EuroCDP/ms_IPs/PLL/PLL-main/schematic/xschem/ned_DFF.sym
** sch_path: /home/moya/Documents/EuroCDP/ms_IPs/PLL/PLL-main/schematic/xschem/ned_DFF.sch
.subckt ned_DFF CLK VDD D Q VSS
*.PININFO D:I VDD:B VSS:B Q:O CLK:I
x1 VDD CLK VSS net1 D tg
x3 VDD CLKB VSS net3 net2 tg
x4 VDD CLKB VSS net1 net5 tg
x5 VDD CLK VSS net3 net4 tg
x2 VDD CLK CLKB VSS inverter
x6 VDD net1 net2 VSS inverter
x7 VDD net2 net5 VSS inverter
x8 VDD Q net4 VSS inverter
x9 VDD net3 Q VSS inverter
.ends

* expanding   symbol:  MUX.sym # of pins=6
** sym_path: /home/moya/Documents/EuroCDP/ms_IPs/PLL/PLL-main/schematic/xschem/MUX.sym
** sch_path: /home/moya/Documents/EuroCDP/ms_IPs/PLL/PLL-main/schematic/xschem/MUX.sch
.subckt MUX VDD SEL IN1 VOUT VSS IN2
*.PININFO SEL:I IN1:I IN2:I VOUT:O VDD:B VSS:B
x2 VDD net3 net1 IN1 VSS AND
x3 VDD net2 SEL IN2 VSS AND
M4 net1 SEL VDD VDD pfet_03v3 L=0.56u W=6.72u nf=1 m=1
M5 net1 SEL VSS VSS nfet_03v3 L=0.56u W=3.36u nf=1 m=1
x1 VDD net3 net2 VOUT VSS OR
.ends

* expanding   symbol:  AND.sym # of pins=5
** sym_path: /home/moya/Documents/EuroCDP/ms_IPs/PLL/PLL-main/schematic/xschem/AND.sym
** sch_path: /home/moya/Documents/EuroCDP/ms_IPs/PLL/PLL-main/schematic/xschem/AND.sch
.subckt AND VDD VOUT A B VSS
*.PININFO VDD:B VSS:B A:I B:I VOUT:O
M1 net1 A net2 VSS nfet_03v3 L=0.56u W=2.24u nf=1 m=1
M2 net1 A VDD VDD pfet_03v3 L=0.56u W=2.24u nf=1 m=1
M3 net1 B VDD VDD pfet_03v3 L=0.56u W=2.24u nf=1 m=1
M4 net2 B VSS VSS nfet_03v3 L=0.56u W=2.24u nf=1 m=1
M5 VOUT net1 VDD VDD pfet_03v3 L=0.56u W=2.24u nf=1 m=1
M6 VOUT net1 VSS VSS nfet_03v3 L=0.56u W=1.12u nf=1 m=1
.ends

* expanding   symbol:  TR_Gate.sym # of pins=5
** sym_path: /home/moya/Documents/EuroCDP/ms_IPs/PLL/PLL-main/schematic/xschem/TR_Gate.sym
** sch_path: /home/moya/Documents/EuroCDP/ms_IPs/PLL/PLL-main/schematic/xschem/TR_Gate.sch
.subckt TR_Gate OUT VDD VSS IN CLK
*.PININFO VDD:B VSS:B IN:I OUT:O CLK:I
M1 IN net1 OUT VDD pfet_03v3 L=0.5u W=3.36u nf=1 m=1
M2 IN CLK OUT VSS nfet_03v3 L=0.5u W=3.36u nf=1 m=1
M3 net1 CLK VDD VDD pfet_03v3 L=0.5u W=3.36u nf=1 m=1
M4 net1 CLK VSS VSS nfet_03v3 L=0.5u W=1.68u nf=1 m=1
.ends

* expanding   symbol:  GF_INV.sym # of pins=4
** sym_path: /home/moya/Documents/EuroCDP/ms_IPs/PLL/PLL-main/schematic/xschem/GF_INV.sym
** sch_path: /home/moya/Documents/EuroCDP/ms_IPs/PLL/PLL-main/schematic/xschem/GF_INV.sch
.subckt GF_INV VSS VDD OUT IN
*.PININFO VDD:B VSS:B IN:I OUT:O
M1 OUT IN VSS VSS nfet_03v3 L=0.5u W=0.5u nf=1 m=1
M2 OUT IN VDD VDD pfet_03v3 L=0.5u W=1u nf=1 m=1
.ends

* expanding   symbol:  Buffer_V_2.sym # of pins=4
** sym_path: /home/moya/Documents/EuroCDP/ms_IPs/PLL/PLL-main/schematic/xschem/Buffer_V_2.sym
** sch_path: /home/moya/Documents/EuroCDP/ms_IPs/PLL/PLL-main/schematic/xschem/Buffer_V_2.sch
.subckt Buffer_V_2 VDD IN out VSS
*.PININFO VDD:B VSS:B IN:I out:I
M1 net1 IN VSS VSS nfet_03v3 L=0.5u W=0.5u nf=1 m=1
M2 net1 IN VDD VDD pfet_03v3 L=0.5u W=1u nf=1 m=1
M3 out net1 VSS VSS nfet_03v3 L=0.5u W=0.5u nf=1 m=1
M4 out net1 VDD VDD pfet_03v3 L=0.5u W=1u nf=1 m=1
.ends

* expanding   symbol:  DelayCell_1.sym # of pins=8
** sym_path: /home/moya/Documents/EuroCDP/ms_IPs/PLL/PLL-main/schematic/xschem/DelayCell_1.sym
** sch_path: /home/moya/Documents/EuroCDP/ms_IPs/PLL/PLL-main/schematic/xschem/DelayCell_1.sch
.subckt DelayCell_1 VDD VSS IN INB VCTRL VCTRL2 OUT OUTB
*.PININFO VDD:B VSS:B IN:I INB:I VCTRL:I VCTRL2:I OUT:O OUTB:O
M2 OUTB OUT VDD VDD pfet_03v3 L=0.84u W=8u nf=1 m=1
M4 OUT OUTB VDD VDD pfet_03v3 L=0.84u W=8u nf=1 m=1
M5 OUTB VCTRL VDD VDD pfet_03v3 L=0.84u W=2.5u nf=1 m=1
M6 OUT VCTRL VDD VDD pfet_03v3 L=0.84u W=2.5u nf=1 m=1
M7 net1 VCTRL2 VSS VSS nfet_03v3 L=0.84u W=20u nf=1 m=1
M8 OUT IN net1 VSS nfet_03v3 L=0.84u W=5u nf=1 m=1
M9 OUTB INB net1 VSS nfet_03v3 L=0.84u W=5u nf=1 m=1
M1 VSS VSS VSS VSS nfet_03v3 L=0.84u W=10u nf=1 m=1
M3 VDD VDD VDD VDD pfet_03v3 L=0.84u W=6u nf=1 m=1
.ends

* expanding   symbol:  D-FF.sym # of pins=6
** sym_path: /home/moya/Documents/EuroCDP/ms_IPs/PLL/PLL-main/schematic/xschem/D-FF.sym
** sch_path: /home/moya/Documents/EuroCDP/ms_IPs/PLL/PLL-main/schematic/xschem/D-FF.sch
.subckt D-FF VDD VSS CLK D Q Q-
*.PININFO VDD:B VSS:B CLK:I D:I Q:O Q-:O
x1 net1 VDD VSS D CLKB TR_Gate
x2 net1 VDD VSS net3 CLK TR_Gate
x3 VSS VDD net2 net1 INV
x4 VSS VDD net3 net2 INV
x5 net5 VDD VSS net2 CLK TR_Gate
x6 net5 VDD VSS net4 CLKB TR_Gate
x8 VSS VDD net4 Q INV
x9 VSS VDD CLKB CLK INV
x10 VSS VDD Q- Q INV
M1 Q net5 VSS VSS nfet_03v3 L=0.5u W=2u nf=1 m=1
M2 Q net5 VDD VDD pfet_03v3 L=0.5u W=4u nf=1 m=1
.ends

* expanding   symbol:  inverter_1.sym # of pins=4
** sym_path: /home/moya/Documents/EuroCDP/ms_IPs/PLL/PLL-main/schematic/xschem/inverter_1.sym
** sch_path: /home/moya/Documents/EuroCDP/ms_IPs/PLL/PLL-main/schematic/xschem/inverter_1.sch
.subckt inverter_1 VDD VIN VOUT VSS
*.PININFO VDD:B VIN:I VOUT:O VSS:B
M4 VOUT VIN VDD VDD pfet_03v3 L=0.56u W=4.48u nf=1 m=1
M5 VOUT VIN VSS VSS nfet_03v3 L=0.56u W=2.24u nf=1 m=1
.ends

* expanding   symbol:  tg.sym # of pins=5
** sym_path: /home/moya/Documents/EuroCDP/ms_IPs/PLL/PLL-main/schematic/xschem/tg.sym
** sch_path: /home/moya/Documents/EuroCDP/ms_IPs/PLL/PLL-main/schematic/xschem/tg.sch
.subckt tg VDD CLK VSS OUT IN
*.PININFO VDD:B VSS:B CLK:I IN:I OUT:O
x1 VDD CLK net1 VSS inverter
M1 OUT net1 IN VDD pfet_03v3 L=0.56u W=3.36u nf=1 m=1
M2 OUT CLK IN VSS nfet_03v3 L=0.56u W=3.36u nf=1 m=1
.ends

* expanding   symbol:  NAND.sym # of pins=5
** sym_path: /home/moya/Documents/EuroCDP/ms_IPs/PLL/PLL-main/schematic/xschem/NAND.sym
** sch_path: /home/moya/Documents/EuroCDP/ms_IPs/PLL/PLL-main/schematic/xschem/NAND.sch
.subckt NAND VDD VOUT A B VSS
*.PININFO VDD:B VSS:B A:I B:I VOUT:O
M1 VOUT A net1 VSS nfet_03v3 L=0.56u W=2.24u nf=1 m=1
M2 VOUT A VDD VDD pfet_03v3 L=0.56u W=2.24u nf=1 m=1
M3 VOUT B VDD VDD pfet_03v3 L=0.56u W=2.24u nf=1 m=1
M4 net1 B VSS VSS nfet_03v3 L=0.56u W=2.24u nf=1 m=1
.ends

* expanding   symbol:  3_inp_NOR.sym # of pins=6
** sym_path: /home/moya/Documents/EuroCDP/ms_IPs/PLL/PLL-main/schematic/xschem/3_inp_NOR.sym
** sch_path: /home/moya/Documents/EuroCDP/ms_IPs/PLL/PLL-main/schematic/xschem/3_inp_NOR.sch
.subckt 3_inp_NOR VDD A B C VOUT VSS
*.PININFO VSS:B VDD:B A:I B:I C:I VOUT:O
M1 VOUT A VSS VSS nfet_03v3 L=0.56u W=1.12u nf=1 m=1
M2 net1 B net2 VDD pfet_03v3 L=0.56u W=6.72u nf=1 m=1
M3 VOUT B VSS VSS nfet_03v3 L=0.56u W=1.12u nf=1 m=1
M4 VOUT C VSS VSS nfet_03v3 L=0.56u W=1.12u nf=1 m=1
M5 VOUT C net1 VDD pfet_03v3 L=0.56u W=6.72u nf=1 m=1
M6 net2 A VDD VDD pfet_03v3 L=0.56u W=6.72u nf=1 m=1
.ends

* expanding   symbol:  MOD_DFF_latest.sym # of pins=9
** sym_path: /home/moya/Documents/EuroCDP/ms_IPs/PLL/PLL-main/schematic/xschem/MOD_DFF_latest.sym
** sch_path: /home/moya/Documents/EuroCDP/ms_IPs/PLL/PLL-main/schematic/xschem/MOD_DFF_latest.sch
.subckt MOD_DFF_latest VDD LD DATA Q QB D1 VSS CLK G-CLK
*.PININFO VDD:B LD:I VSS:B D1:I CLK:I G-CLK:I Q:O QB:O DATA:I
x1 VDD QB net1 ab net2 VSS tspc_FF
x2 VDD LD D1 net2 VSS DATA MUX
x3 VDD LD net1 Q VSS DATA MUX
x4 VDD LD CLK ab VSS G-CLK MUX
.ends

* expanding   symbol:  NOR.sym # of pins=5
** sym_path: /home/moya/Documents/EuroCDP/ms_IPs/PLL/PLL-main/schematic/xschem/NOR.sym
** sch_path: /home/moya/Documents/EuroCDP/ms_IPs/PLL/PLL-main/schematic/xschem/NOR.sch
.subckt NOR VDD A B VOUT VSS
*.PININFO VSS:B VDD:B A:I B:I VOUT:O
M1 VOUT A VSS VSS nfet_03v3 L=0.56u W=1.12u nf=1 m=1
M2 VOUT B net1 VDD pfet_03v3 L=0.56u W=4.48u nf=1 m=1
M3 VOUT B VSS VSS nfet_03v3 L=0.56u W=1.12u nf=1 m=1
M6 net1 A VDD VDD pfet_03v3 L=0.56u W=4.48u nf=1 m=1
.ends

* expanding   symbol:  INV.sym # of pins=4
** sym_path: /home/moya/Documents/EuroCDP/ms_IPs/PLL/PLL-main/schematic/xschem/INV.sym
** sch_path: /home/moya/Documents/EuroCDP/ms_IPs/PLL/PLL-main/schematic/xschem/INV.sch
.subckt INV VSS VDD OUT IN
*.PININFO VDD:B VSS:B IN:I OUT:O
M1 OUT IN VSS VSS nfet_03v3 L=0.5u W=2u nf=1 m=1
M2 OUT IN VDD VDD pfet_03v3 L=0.5u W=4u nf=1 m=1
.ends

* expanding   symbol:  tspc_FF.sym # of pins=6
** sym_path: /home/moya/Documents/EuroCDP/ms_IPs/PLL/PLL-main/schematic/xschem/tspc_FF.sym
** sch_path: /home/moya/Documents/EuroCDP/ms_IPs/PLL/PLL-main/schematic/xschem/tspc_FF.sch
.subckt tspc_FF VDD QB Q CLK D VSS
*.PININFO D:I CLK:I VDD:B VSS:B QB:O Q:O
M1 net1 D VSS VSS nfet_03v3 L=0.56u W=1.12u nf=1 m=1
M2 net1 CLK net2 VDD pfet_03v3 L=0.56u W=4.48u nf=1 m=1
M3 net2 D VDD VDD pfet_03v3 L=0.56u W=4.48u nf=1 m=1
M4 net3 CLK VDD VDD pfet_03v3 L=0.56u W=2.24u nf=1 m=1
M5 net3 net1 net4 VSS nfet_03v3 L=0.56u W=2.24u nf=1 m=1
M6 net4 CLK VSS VSS nfet_03v3 L=0.56u W=2.24u nf=1 m=1
M7 QB net3 VDD VDD pfet_03v3 L=0.56u W=2.24u nf=1 m=1
M8 QB CLK net5 VSS nfet_03v3 L=0.56u W=2.24u nf=1 m=1
M9 net5 net3 VSS VSS nfet_03v3 L=0.56u W=2.24u nf=1 m=1
M10 Q QB VDD VDD pfet_03v3 L=0.56u W=2.24u nf=1 m=1
M11 Q QB VSS VSS nfet_03v3 L=0.56u W=1.12u nf=1 m=1
.ends
